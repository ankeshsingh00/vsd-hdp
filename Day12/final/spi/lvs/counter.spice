* NGSPICE file created from counter.ext - technology: sky130A

* Black-box entry subcircuit for sky130_fd_sc_hd__dfrtp_1 abstract view
.subckt sky130_fd_sc_hd__dfrtp_1 CLK D RESET_B VGND VNB VPB VPWR Q
.ends

* Black-box entry subcircuit for sky130_fd_sc_hd__clkbuf_4 abstract view
.subckt sky130_fd_sc_hd__clkbuf_4 A VGND VNB VPB VPWR X
.ends

* Black-box entry subcircuit for sky130_fd_sc_hd__fill_2 abstract view
.subckt sky130_fd_sc_hd__fill_2 VGND VNB VPB VPWR
.ends

* Black-box entry subcircuit for sky130_fd_sc_hd__decap_4 abstract view
.subckt sky130_fd_sc_hd__decap_4 VGND VNB VPB VPWR
.ends

* Black-box entry subcircuit for sky130_fd_sc_hd__fill_1 abstract view
.subckt sky130_fd_sc_hd__fill_1 VGND VNB VPB VPWR
.ends

* Black-box entry subcircuit for sky130_fd_sc_hd__decap_6 abstract view
.subckt sky130_fd_sc_hd__decap_6 VGND VNB VPB VPWR
.ends

* Black-box entry subcircuit for sky130_fd_sc_hd__nor2_1 abstract view
.subckt sky130_fd_sc_hd__nor2_1 A B VGND VNB VPB VPWR Y
.ends

* Black-box entry subcircuit for sky130_fd_sc_hd__a21oi_1 abstract view
.subckt sky130_fd_sc_hd__a21oi_1 A1 A2 B1 VGND VNB VPB VPWR Y
.ends

* Black-box entry subcircuit for sky130_fd_sc_hd__and3_1 abstract view
.subckt sky130_fd_sc_hd__and3_1 A B C VGND VNB VPB VPWR X
.ends

* Black-box entry subcircuit for sky130_fd_sc_hd__decap_3 abstract view
.subckt sky130_fd_sc_hd__decap_3 VGND VNB VPB VPWR
.ends

* Black-box entry subcircuit for sky130_fd_sc_hd__inv_2 abstract view
.subckt sky130_fd_sc_hd__inv_2 A VGND VNB VPB VPWR Y
.ends

* Black-box entry subcircuit for sky130_fd_sc_hd__xor2_1 abstract view
.subckt sky130_fd_sc_hd__xor2_1 A B VGND VNB VPB VPWR X
.ends

* Black-box entry subcircuit for sky130_fd_sc_hd__o21ba_1 abstract view
.subckt sky130_fd_sc_hd__o21ba_1 A1 A2 B1_N VGND VNB VPB VPWR X
.ends

* Black-box entry subcircuit for sky130_fd_sc_hd__clkbuf_16 abstract view
.subckt sky130_fd_sc_hd__clkbuf_16 A VGND VNB VPB VPWR X
.ends

* Black-box entry subcircuit for sky130_fd_sc_hd__and4_1 abstract view
.subckt sky130_fd_sc_hd__and4_1 A B C D VGND VNB VPB VPWR X
.ends

* Black-box entry subcircuit for sky130_ef_sc_hd__decap_12 abstract view
.subckt sky130_ef_sc_hd__decap_12 VPWR VGND VPB VNB
.ends

* Black-box entry subcircuit for sky130_fd_sc_hd__decap_8 abstract view
.subckt sky130_fd_sc_hd__decap_8 VGND VNB VPB VPWR
.ends

* Black-box entry subcircuit for sky130_fd_sc_hd__tapvpwrvgnd_1 abstract view
.subckt sky130_fd_sc_hd__tapvpwrvgnd_1 VGND VPWR
.ends

* Black-box entry subcircuit for sky130_fd_sc_hd__buf_1 abstract view
.subckt sky130_fd_sc_hd__buf_1 A VGND VNB VPB VPWR X
.ends

* Black-box entry subcircuit for sky130_fd_sc_hd__dlygate4sd3_1 abstract view
.subckt sky130_fd_sc_hd__dlygate4sd3_1 A VGND VNB VPB VPWR X
.ends

.subckt counter VGND VPWR clk count[0] count[1] count[2] count[3] count[4] count[5]
+ count[6] count[7] reset
X_49_ clknet_1_1__leaf_clk _05_ _13_ VGND VGND VPWR VPWR net7 sky130_fd_sc_hd__dfrtp_1
Xoutput7 net7 VGND VGND VPWR VPWR count[5] sky130_fd_sc_hd__clkbuf_4
X_48_ clknet_1_1__leaf_clk _04_ _12_ VGND VGND VPWR VPWR net6 sky130_fd_sc_hd__dfrtp_1
Xoutput8 net8 VGND VGND VPWR VPWR count[6] sky130_fd_sc_hd__clkbuf_4
XFILLER_0_9_29 VGND VGND VPWR VPWR sky130_fd_sc_hd__fill_2
X_47_ clknet_1_0__leaf_clk _03_ _11_ VGND VGND VPWR VPWR net5 sky130_fd_sc_hd__dfrtp_1
Xoutput9 net9 VGND VGND VPWR VPWR count[7] sky130_fd_sc_hd__clkbuf_4
XFILLER_0_9_3 VGND VGND VPWR VPWR sky130_fd_sc_hd__decap_4
XFILLER_0_0_7 VGND VGND VPWR VPWR sky130_fd_sc_hd__fill_1
X_46_ clknet_1_0__leaf_clk _02_ _10_ VGND VGND VPWR VPWR net4 sky130_fd_sc_hd__dfrtp_1
XFILLER_0_9_19 VGND VGND VPWR VPWR sky130_fd_sc_hd__decap_6
X_29_ _18_ _19_ VGND VGND VPWR VPWR _05_ sky130_fd_sc_hd__nor2_1
X_28_ net13 _17_ net18 VGND VGND VPWR VPWR _19_ sky130_fd_sc_hd__a21oi_1
X_45_ clknet_1_0__leaf_clk _01_ _09_ VGND VGND VPWR VPWR net3 sky130_fd_sc_hd__dfrtp_1
X_44_ clknet_1_0__leaf_clk _00_ _08_ VGND VGND VPWR VPWR net2 sky130_fd_sc_hd__dfrtp_1
X_27_ net6 net7 _17_ VGND VGND VPWR VPWR _18_ sky130_fd_sc_hd__and3_1
XPHY_0 VGND VGND VPWR VPWR sky130_fd_sc_hd__decap_3
X_43_ net1 VGND VGND VPWR VPWR _15_ sky130_fd_sc_hd__inv_2
X_26_ net13 _17_ VGND VGND VPWR VPWR _04_ sky130_fd_sc_hd__xor2_1
XPHY_1 VGND VGND VPWR VPWR sky130_fd_sc_hd__decap_3
X_42_ net1 VGND VGND VPWR VPWR _14_ sky130_fd_sc_hd__inv_2
X_25_ net15 _16_ _17_ VGND VGND VPWR VPWR _03_ sky130_fd_sc_hd__o21ba_1
XPHY_2 VGND VGND VPWR VPWR sky130_fd_sc_hd__decap_3
Xclkbuf_0_clk clk VGND VGND VPWR VPWR clknet_0_clk sky130_fd_sc_hd__clkbuf_16
X_24_ net2 net3 net4 net5 VGND VGND VPWR VPWR _17_ sky130_fd_sc_hd__and4_1
X_41_ net1 VGND VGND VPWR VPWR _13_ sky130_fd_sc_hd__inv_2
XPHY_3 VGND VGND VPWR VPWR sky130_fd_sc_hd__decap_3
XFILLER_0_5_3 VPWR VGND VPWR VGND sky130_ef_sc_hd__decap_12
X_40_ net1 VGND VGND VPWR VPWR _12_ sky130_fd_sc_hd__inv_2
X_23_ net2 net3 net4 VGND VGND VPWR VPWR _16_ sky130_fd_sc_hd__and3_1
XPHY_4 VGND VGND VPWR VPWR sky130_fd_sc_hd__decap_3
XFILLER_0_4_15 VGND VGND VPWR VPWR sky130_fd_sc_hd__fill_2
X_22_ net10 VGND VGND VPWR VPWR _00_ sky130_fd_sc_hd__inv_2
XPHY_5 VGND VGND VPWR VPWR sky130_fd_sc_hd__decap_3
XFILLER_0_4_49 VGND VGND VPWR VPWR sky130_fd_sc_hd__decap_8
XPHY_6 VGND VGND VPWR VPWR sky130_fd_sc_hd__decap_3
XFILLER_0_3_3 VGND VGND VPWR VPWR sky130_fd_sc_hd__decap_3
Xinput1 reset VGND VGND VPWR VPWR net1 sky130_fd_sc_hd__clkbuf_4
XPHY_7 VGND VGND VPWR VPWR sky130_fd_sc_hd__decap_3
XPHY_8 VGND VGND VPWR VPWR sky130_fd_sc_hd__decap_3
XPHY_9 VGND VGND VPWR VPWR sky130_fd_sc_hd__decap_3
XFILLER_0_8_20 VGND VGND VPWR VPWR sky130_fd_sc_hd__fill_1
XTAP_30 VGND VPWR sky130_fd_sc_hd__tapvpwrvgnd_1
XFILLER_0_5_44 VGND VGND VPWR VPWR sky130_fd_sc_hd__decap_3
XFILLER_0_2_56 VGND VGND VPWR VPWR sky130_fd_sc_hd__fill_1
XFILLER_0_8_44 VGND VGND VPWR VPWR sky130_fd_sc_hd__fill_1
XTAP_31 VGND VPWR sky130_fd_sc_hd__tapvpwrvgnd_1
XTAP_20 VGND VPWR sky130_fd_sc_hd__tapvpwrvgnd_1
Xclkbuf_1_0__f_clk clknet_0_clk VGND VGND VPWR VPWR clknet_1_0__leaf_clk sky130_fd_sc_hd__clkbuf_16
X_39_ net1 VGND VGND VPWR VPWR _11_ sky130_fd_sc_hd__inv_2
XFILLER_0_8_56 VGND VGND VPWR VPWR sky130_fd_sc_hd__fill_1
XTAP_21 VGND VPWR sky130_fd_sc_hd__tapvpwrvgnd_1
X_38_ net1 VGND VGND VPWR VPWR _10_ sky130_fd_sc_hd__inv_2
XFILLER_0_1_9 VGND VGND VPWR VPWR sky130_fd_sc_hd__fill_2
Xhold1 net2 VGND VGND VPWR VPWR net10 sky130_fd_sc_hd__buf_1
XTAP_22 VGND VPWR sky130_fd_sc_hd__tapvpwrvgnd_1
X_37_ net1 VGND VGND VPWR VPWR _09_ sky130_fd_sc_hd__inv_2
Xhold2 net9 VGND VGND VPWR VPWR net11 sky130_fd_sc_hd__dlygate4sd3_1
XTAP_23 VGND VPWR sky130_fd_sc_hd__tapvpwrvgnd_1
XFILLER_0_5_15 VGND VGND VPWR VPWR sky130_fd_sc_hd__fill_1
X_36_ net1 VGND VGND VPWR VPWR _08_ sky130_fd_sc_hd__inv_2
Xhold3 net8 VGND VGND VPWR VPWR net12 sky130_fd_sc_hd__dlygate4sd3_1
XTAP_24 VGND VPWR sky130_fd_sc_hd__tapvpwrvgnd_1
X_35_ _16_ net17 VGND VGND VPWR VPWR _02_ sky130_fd_sc_hd__nor2_1
Xhold4 net6 VGND VGND VPWR VPWR net13 sky130_fd_sc_hd__dlygate4sd3_1
XTAP_25 VGND VPWR sky130_fd_sc_hd__tapvpwrvgnd_1
X_51_ clknet_1_1__leaf_clk _07_ _15_ VGND VGND VPWR VPWR net9 sky130_fd_sc_hd__dfrtp_1
X_34_ net10 net3 net16 VGND VGND VPWR VPWR _21_ sky130_fd_sc_hd__a21oi_1
Xhold5 net3 VGND VGND VPWR VPWR net14 sky130_fd_sc_hd__dlygate4sd3_1
XPHY_10 VGND VGND VPWR VPWR sky130_fd_sc_hd__decap_3
XTAP_26 VGND VPWR sky130_fd_sc_hd__tapvpwrvgnd_1
XFILLER_0_6_3 VGND VGND VPWR VPWR sky130_fd_sc_hd__fill_2
X_33_ net10 net14 VGND VGND VPWR VPWR _01_ sky130_fd_sc_hd__xor2_1
X_50_ clknet_1_1__leaf_clk _06_ _14_ VGND VGND VPWR VPWR net8 sky130_fd_sc_hd__dfrtp_1
Xhold6 net5 VGND VGND VPWR VPWR net15 sky130_fd_sc_hd__dlygate4sd3_1
Xclkbuf_1_1__f_clk clknet_0_clk VGND VGND VPWR VPWR clknet_1_1__leaf_clk sky130_fd_sc_hd__clkbuf_16
XTAP_27 VGND VPWR sky130_fd_sc_hd__tapvpwrvgnd_1
XPHY_11 VGND VGND VPWR VPWR sky130_fd_sc_hd__decap_3
X_32_ net11 _20_ VGND VGND VPWR VPWR _07_ sky130_fd_sc_hd__xor2_1
Xhold7 net4 VGND VGND VPWR VPWR net16 sky130_fd_sc_hd__dlygate4sd3_1
XPHY_12 VGND VGND VPWR VPWR sky130_fd_sc_hd__decap_3
XTAP_28 VGND VPWR sky130_fd_sc_hd__tapvpwrvgnd_1
X_31_ net6 net7 net8 _17_ VGND VGND VPWR VPWR _20_ sky130_fd_sc_hd__and4_1
Xhold8 _21_ VGND VGND VPWR VPWR net17 sky130_fd_sc_hd__dlygate4sd3_1
XFILLER_0_4_3 VPWR VGND VPWR VGND sky130_ef_sc_hd__decap_12
XPHY_13 VGND VGND VPWR VPWR sky130_fd_sc_hd__decap_3
XTAP_29 VGND VPWR sky130_fd_sc_hd__tapvpwrvgnd_1
X_30_ net12 _18_ VGND VGND VPWR VPWR _06_ sky130_fd_sc_hd__xor2_1
XFILLER_0_0_55 VGND VGND VPWR VPWR sky130_fd_sc_hd__fill_1
Xhold9 net7 VGND VGND VPWR VPWR net18 sky130_fd_sc_hd__dlygate4sd3_1
XPHY_14 VGND VGND VPWR VPWR sky130_fd_sc_hd__decap_3
XFILLER_0_9_43 VPWR VGND VPWR VGND sky130_ef_sc_hd__decap_12
XPHY_15 VGND VGND VPWR VPWR sky130_fd_sc_hd__decap_3
XFILLER_0_9_55 VGND VGND VPWR VPWR sky130_fd_sc_hd__fill_1
Xoutput2 net2 VGND VGND VPWR VPWR count[0] sky130_fd_sc_hd__clkbuf_4
XFILLER_0_2_3 VGND VGND VPWR VPWR sky130_fd_sc_hd__fill_2
XPHY_16 VGND VGND VPWR VPWR sky130_fd_sc_hd__decap_3
XPHY_17 VGND VGND VPWR VPWR sky130_fd_sc_hd__decap_3
Xoutput3 net3 VGND VGND VPWR VPWR count[1] sky130_fd_sc_hd__clkbuf_4
Xoutput4 net4 VGND VGND VPWR VPWR count[2] sky130_fd_sc_hd__clkbuf_4
XPHY_18 VGND VGND VPWR VPWR sky130_fd_sc_hd__decap_3
XFILLER_0_3_37 VGND VGND VPWR VPWR sky130_fd_sc_hd__fill_2
XPHY_19 VGND VGND VPWR VPWR sky130_fd_sc_hd__decap_3
Xoutput5 net5 VGND VGND VPWR VPWR count[3] sky130_fd_sc_hd__clkbuf_4
XFILLER_0_0_3 VGND VGND VPWR VPWR sky130_fd_sc_hd__decap_4
XFILLER_0_9_37 VGND VGND VPWR VPWR sky130_fd_sc_hd__fill_2
Xoutput6 net6 VGND VGND VPWR VPWR count[4] sky130_fd_sc_hd__clkbuf_4
.ends
